# Ansys Electronics Desktop project, version 2018.2
materials:
  vacuum: permittivity=1
  lead: permeability=0.999983 conductivity=5000000
  M19_24G_x: permeability{BType=normal HUnit=A_per_meter BUnit=tesla curve (0, 0) (22.28, 0.05) (25.46, 0.1) (31.83, 0.15) (47.74, 0.36) (63.66, 0.54) (79.57, 0.65) (159.15, 0.99) (318.3, 1.2) (477.46, 1.28) (636.61, 1.33) (795.77, 1.36) (1591.5, 1.44) (3183, 1.52) (4774.6, 1.58) (6366.1, 1.63) (7957.7, 1.67) (15915, 1.8) (31830, 1.9) (111407, 2) (190984, 2.1) (350138, 2.3) (509292, 2.5)} core_loss_type="Electrical Steel" core_loss_kh=164.2 core_loss_kc=1.3 core_loss_ke=1.72 mass_density=7650
  NdFe42_N: CoordinateSystemType=Cylindrical permittivity=1 permeability=1.05 conductivity=625000 magnetic_coercivity{Magnitude=-996613A_per_meter DirComp1=1 DirComp2=0 DirComp3=0} lande_g_factor=2
  NdFe42_S: CoordinateSystemType=Cylindrical permittivity=1 permeability=1.05 conductivity=625000 magnetic_coercivity{Magnitude=-996613A_per_meter DirComp1=-1 DirComp2=0 DirComp3=0} lande_g_factor=2
  M19-24G_2DSF0.950: permeability{BType=normal HUnit=A_per_meter BUnit=tesla curve (0, 0) (22.28, 0.0475014) (25.46, 0.0950016) (31.83, 0.142502) (47.74, 0.342003) (63.66, 0.513004) (79.57, 0.617505) (159.15, 0.94051) (318.3, 1.14002) (477.46, 1.21603) (636.61, 1.26354) (795.77, 1.29205) (1591.5, 1.3681) (3183, 1.4442) (4774.6, 1.5013) (6366.1, 1.5489) (7957.7, 1.587) (15915, 1.711) (31830, 1.807) (111407, 1.907) (190984, 2.007) (350138, 2.207) (509292, 2.407) (2100830, 4.407)} core_loss_type="Electrical Steel" core_loss_kc=4.55322 mass_density=7267.5
  NdFe42_2DSF1.000_N: CoordinateSystemType=Cylindrical permeability=1.05 conductivity=625000 magnetic_coercivity{Magnitude=-996613A_per_meter DirComp1=1 DirComp2=0 DirComp3=0}
  NdFe42_2DSF1.000_S: CoordinateSystemType=Cylindrical permeability=1.05 conductivity=625000 magnetic_coercivity{Magnitude=-996613A_per_meter DirComp1=-1 DirComp2=0 DirComp3=0}
  copper: permeability=0.999991 conductivity=58000000

design Parta (Maxwell 2D, Magnetostatic, XY geometry, model units mm)
variables:
  fractions = 1
geometry:
  rotor [M19_24G_x] = user_primitive(RMxprt/PMCore.dll, DiaGap=100mm, DiaYoke=34mm, Length=0mm, Poles=4, PoleType=1, Embrace=0.8, ThickMag=4mm, WidthMag=0mm, Offset=0mm, Bridge=0mm, Rib=0mm, LenRegion=0mm, InfoCore=0)
  Magnet_1 [NdFe42_S] = user_primitive(RMxprt/PMCore.dll, DiaGap=100mm, DiaYoke=34mm, Length=0mm, Poles=4, PoleType=1, Embrace=0.8, ThickMag=4mm, WidthMag=0mm, Offset=0mm, Bridge=0mm, Rib=0mm, LenRegion=0mm, InfoCore=2)
  Magnet_2 [NdFe42_N], Magnet_3 [NdFe42_S], Magnet_4 [NdFe42_N] = Magnet_1.duplicate_around_axis(axis=Z, angle=90deg, total=4)
  Stator [M19_24G_x] = circle(normal=Z, centre=(0mm, 0mm, 0mm), radius=80mm)
  Circle2 = circle(normal=Z, centre=(0mm, 0mm, 0mm), radius=51mm)
  Stator.subtract(Circle2)
  Inner_region [vacuum] = user_primitive(RMxprt/PMCore.dll, DiaGap=100mm, DiaYoke=34mm, Length=0mm, Poles=4, PoleType=1, Embrace=0.8, ThickMag=4mm, WidthMag=0mm, Offset=0mm, Bridge=0mm, Rib=0mm, LenRegion=0mm, InfoCore=100)
  Band [vacuum] = user_primitive(RMxprt/Band.dll, DiaGap=101mm, DiaYoke=160mm, Length=0mm, SegAngle=0deg, Fractions=1, HalfAxial=0, InfoCore=100)
  Polyline1 [non-model] = polyline(z=0mm, xy in mm: (-50.5, 0) (0, 50.5) (50.5, 0), Arc from point 0 over 3)
  Positive [non-model] = polyline(z=0mm, xy in mm: (-50.5, 0) (-35.708892, 35.708892) (3.0922332e-15, 50.5), AngularArc from point 0 over 3 centre=(0mm, 0mm, 0mm) angle=-90deg plane=XY)
  Negative [non-model] = polyline(z=0mm, xy in mm: (50.5, 0) (35.708892, 35.708892) (3.0922332e-15, 50.5), AngularArc from point 0 over 3 centre=(0mm, 0mm, 0mm) angle=90deg plane=XY)
boundaries and excitations:
  VectorPotential1: Vector Potential Edges=Band.edge(at (0, 80, 0)) Value=0
mesh:
  SurfApprox_magnets: SurfApproxBased Objects=[Magnet_4, Magnet_2, Magnet_3, Magnet_1] CurvedSurfaceApproxChoice=ManualSettings SurfDev=0.05mm NormalDev=15deg
  SurfApprox_others: SurfApproxBased Objects=[rotor, Stator, Band, Inner_region] CurvedSurfaceApproxChoice=ManualSettings SurfDev=0.08mm NormalDev=15deg
  initial mesh: MeshMethod=AnsoftTAU
setups:
  Setup1: Magnetostatic MaximumPasses=10 MinimumPasses=2 MinimumConvergedPasses=1 PercentRefinement=15 PercentError=1 NonLinearResidual=0.0001
field calculator expressions:
  Bradial = B_Vector | Mag_B | *
  Negatif_mag_b = Mag_B | Neg
reports:
  Radial Air-gap Flux Density for One Pole-pair: Y Component 1 vs Distance
   Plot 1: -Mag_B vs Distance on Setup1 : LastAdaptive

design transient (Maxwell 2D, Transient, XY geometry, model units mm)
options: ModelDepth=100mm Multiplier=fractions
variables:
  fractions = 1
geometry:
  Band [vacuum] = user_primitive(RMxprt/Band, DiaGap=64.36mm, DiaYoke=34mm, Length=0mm, SegAngle=0deg, Fractions=1, HalfAxial=0, InfoCore=0)
  OuterRegion [vacuum] = user_primitive(RMxprt/Band, DiaGap=101mm, DiaYoke=160mm, Length=0mm, SegAngle=0deg, Fractions=fractions, HalfAxial=0, InfoCore=100)
  Tool = user_primitive(RMxprt/Band, DiaGap=65.36mm, DiaYoke=160mm, Length=0mm, SegAngle=0deg, Fractions=fractions, HalfAxial=0, InfoCore=1)
  Stator [M19-24G_2DSF0.950] = user_primitive(RMxprt/SlotCore, DiaGap=65.36mm, DiaYoke=160mm, Length=0mm, Skew=0deg, Slots=36, SlotType=4, Hs0=0.0001mm, Hs01=0mm, Hs1=0mm, Hs2=32.68mm, Bs0=2.85mm, Bs1=1mm, Bs2=0mm, Rs=0mm, FilletType=0, HalfSlot=0, SegAngle=15deg, LenRegion=0mm, InfoCore=0)
  Coil_0 [copper] = user_primitive(RMxprt/LapCoil, DiaGap=65.36mm, DiaYoke=160mm, Length=0mm, Skew=0deg, Slots=36, SlotType=4, Hs0=0.0001mm, Hs1=0mm, Hs2=35mm, Bs0=2.85mm, Bs1=1mm, Bs2=2.85mm, Rs=0mm, FilletType=0, Layers=1, CoilPitch=5, EndExt=0mm, SpanExt=0mm, BendAngle=0deg, SegAngle=15deg, LenRegion=0mm, InfoCoil=2)
  Rotor [M19-24G_2DSF0.950] = user_primitive(RMxprt/PMCore, DiaGap=63.36mm, DiaYoke=0mm, Length=0mm, Poles=4, PoleType=1, Embrace=0.8, ThickMag=4mm, WidthMag=0mm, Offset=0mm, Bridge=0mm, Rib=0mm, LenRegion=0mm, InfoCore=0)
  Mag_0 [NdFe42_2DSF1.000_N] = user_primitive(RMxprt/PMCore, DiaGap=63.63mm, DiaYoke=0mm, Length=0mm, Poles=4, PoleType=1, Embrace=0.8, ThickMag=4mm, WidthMag=0mm, Offset=0mm, Bridge=0mm, Rib=0mm, LenRegion=0mm, InfoCore=2)
  Mag_1 [NdFe42_2DSF1.000_S], Mag_2 [NdFe42_2DSF1.000_N], Mag_3 [NdFe42_2DSF1.000_S] = Mag_0.duplicate_around_axis(axis=Z, angle=90deg, total=4)
  InnerRegion [vacuum] = user_primitive(RMxprt/PMCore, DiaGap=64.3mm, DiaYoke=34mm, Length=0mm, Poles=4, PoleType=1, Embrace=0.8, ThickMag=4mm, WidthMag=0mm, Offset=0mm, Bridge=0mm, Rib=0mm, LenRegion=0mm, InfoCore=100)
  Tool_1 = Tool.copy()
  Band.subtract(Tool_1)
  Tool_2 = Tool.copy()
  InnerRegion.subtract(Tool_2)
  Tool_4 = Tool.copy()
  Stator.subtract(Tool_4)
  Tool_5 = Tool.copy()
  Coil_0.subtract(Tool_5)
  Tool_6 = Tool.copy()
  Tool_6.delete()
  Tool_7 = Tool.copy()
  Tool_7.delete()
  Tool_8 = Tool.copy()
  Tool_8.delete()
  Tool_9 = Tool.copy()
  Tool_9.delete()
  Tool_10 = Tool.copy()
  Tool_10.delete()
  Tool_11 = Tool.copy()
  Tool_11.delete()
  Tool_12 = Tool.copy()
  Tool_12.delete()
  Tool_13 = Tool.copy()
  Tool_13.delete()
  Tool_14 = Tool.copy()
  Tool_14.delete()
  Tool_15 = Tool.copy()
  Tool_15.delete()
  Tool_16 = Tool.copy()
  Tool_16.delete()
  Tool_17 = Tool.copy()
  Tool_17.delete()
  Tool_18 = Tool.copy()
  Tool_18.delete()
  Tool_19 = Tool.copy()
  Tool_19.delete()
  Tool_20 = Tool.copy()
  Tool_20.delete()
  Tool_21 = Tool.copy()
  Tool_21.delete()
  Tool_22 = Tool.copy()
  Tool_22.delete()
  Tool_23 = Tool.copy()
  Tool_23.delete()
  Tool_24 = Tool.copy()
  Tool_24.delete()
  Tool_25 = Tool.copy()
  Tool_25.delete()
  Tool_26 = Tool.copy()
  Tool_26.delete()
  Tool_27 = Tool.copy()
  Tool_27.delete()
  Tool_28 = Tool.copy()
  Tool_28.delete()
  Tool_30 = Tool.copy()
  Mag_0.subtract(Tool_30)
  Tool_31 = Tool.copy()
  Mag_1.subtract(Tool_31)
  Tool_32 = Tool.copy()
  Mag_2.subtract(Tool_32)
  Mag_3.subtract(Tool)
  Coil_0_1..Coil_0_35 [copper] = Coil_0.duplicate_around_axis(axis=Z, angle=10deg, total=36)
motion:
  MotionSetup1: Band Move_Type=Rotate Coordinate_System=Global Axis=Z Is_Positive=true InitPos=15deg Angular_Velocity=1500rpm Objects=Band
  Moving1: Moving Objects=[Rotor, Mag_0..Mag_3, InnerRegion]
boundaries and excitations:
  VectorPotential1: Vector Potential Edges=OuterRegion.edge(at (0, 80, 0)) Value=0
  PhA_0: Coil Objects=Coil_0 Conductor_number=216 Winding=PhaseA PolarityType=Positive
  Coil_0_2: Coil Objects=Coil_0_2 Conductor_number=216 Winding=PhaseC PolarityType=Negative
  Coil_0_3: Coil Objects=Coil_0_3 Conductor_number=216 Winding=PhaseC PolarityType=Negative
  Coil_0_4: Coil Objects=Coil_0_4 Conductor_number=216 Winding=PhaseB PolarityType=Positive
  Coil_0_5: Coil Objects=Coil_0_5 Conductor_number=216 Winding=PhaseB PolarityType=Positive
  Coil_0_1: Coil Objects=Coil_0_1 Conductor_number=216 Winding=PhaseA PolarityType=Positive
  Coil_0_6: Coil Objects=Coil_0_6 Conductor_number=216 Winding=PhaseA PolarityType=Negative
  Coil_0_7: Coil Objects=Coil_0_7 Conductor_number=216 Winding=PhaseA PolarityType=Negative
  Coil_0_8: Coil Objects=Coil_0_8 Conductor_number=216 Winding=PhaseC PolarityType=Positive
  Coil_0_9: Coil Objects=Coil_0_9 Conductor_number=216 Winding=PhaseC PolarityType=Positive
  Coil_0_10: Coil Objects=Coil_0_10 Conductor_number=216 Winding=PhaseB PolarityType=Negative
  Coil_0_11: Coil Objects=Coil_0_11 Conductor_number=216 Winding=PhaseB PolarityType=Negative
  Coil_0_12: Coil Objects=Coil_0_12 Conductor_number=216 Winding=PhaseA PolarityType=Positive
  Coil_0_13: Coil Objects=Coil_0_13 Conductor_number=216 Winding=PhaseA PolarityType=Positive
  Coil_0_14: Coil Objects=Coil_0_14 Conductor_number=216 Winding=PhaseC PolarityType=Negative
  Coil_0_15: Coil Objects=Coil_0_15 Conductor_number=216 Winding=PhaseC PolarityType=Negative
  Coil_0_16: Coil Objects=Coil_0_16 Conductor_number=216 Winding=PhaseB PolarityType=Positive
  Coil_0_17: Coil Objects=Coil_0_17 Conductor_number=216 Winding=PhaseB PolarityType=Positive
  Coil_0_18: Coil Objects=Coil_0_18 Conductor_number=216 Winding=PhaseA PolarityType=Negative
  Coil_0_19: Coil Objects=Coil_0_19 Conductor_number=216 Winding=PhaseA PolarityType=Negative
  Coil_0_20: Coil Objects=Coil_0_20 Conductor_number=216 Winding=PhaseC PolarityType=Positive
  Coil_0_21: Coil Objects=Coil_0_21 Conductor_number=216 Winding=PhaseC PolarityType=Positive
  Coil_0_22: Coil Objects=Coil_0_22 Conductor_number=216 Winding=PhaseB PolarityType=Negative
  Coil_0_23: Coil Objects=Coil_0_23 Conductor_number=216 Winding=PhaseB PolarityType=Negative
  Coil_0_24: Coil Objects=Coil_0_24 Conductor_number=216 Winding=PhaseA PolarityType=Positive
  Coil_0_25: Coil Objects=Coil_0_25 Conductor_number=216 Winding=PhaseA PolarityType=Positive
  Coil_0_26: Coil Objects=Coil_0_26 Conductor_number=216 Winding=PhaseC PolarityType=Negative
  Coil_0_27: Coil Objects=Coil_0_27 Conductor_number=216 Winding=PhaseC PolarityType=Negative
  Coil_0_28: Coil Objects=Coil_0_28 Conductor_number=216 Winding=PhaseB PolarityType=Positive
  Coil_0_29: Coil Objects=Coil_0_29 Conductor_number=216 Winding=PhaseB PolarityType=Positive
  Coil_0_30: Coil Objects=Coil_0_30 Conductor_number=216 Winding=PhaseA PolarityType=Negative
  Coil_0_31: Coil Objects=Coil_0_31 Conductor_number=216 Winding=PhaseA PolarityType=Negative
  Coil_0_32: Coil Objects=Coil_0_32 Conductor_number=216 Winding=PhaseC PolarityType=Positive
  Coil_0_33: Coil Objects=Coil_0_33 Conductor_number=216 Winding=PhaseC PolarityType=Positive
  Coil_0_34: Coil Objects=Coil_0_34 Conductor_number=216 Winding=PhaseB PolarityType=Negative
  Coil_0_35: Coil Objects=Coil_0_35 Conductor_number=216 Winding=PhaseB PolarityType=Negative
  PhaseA: Winding Group Type=Voltage IsSolid=false Current=0A Resistance=0.821557ohm Inductance=0.000569985H Voltage="179.605 * sin(2*pi*50*time+0.0162481*pi/180)" ParallelBranchesNum=2
  PhaseB: Winding Group Type=Voltage IsSolid=false Current=0A Resistance=0.821557ohm Inductance=0.000569985H Voltage="179.605 * sin(2*pi*50*time+0.0162481*pi/180-2*pi/3)" ParallelBranchesNum=2
  PhaseC: Winding Group Type=Voltage IsSolid=false Current=0A Resistance=0.821557ohm Inductance=0.000569985H Voltage="179.605 * sin(2*pi*50*time+0.0162481*pi/180-4*pi/3)" ParallelBranchesNum=2
mesh:
  SurfApprox_Mag: SurfApproxBased Objects=[Mag_0..Mag_3] CurvedSurfaceApproxChoice=ManualSettings SurfDev=0.05mm NormalDev=15deg
  SurfApprox_Main: SurfApproxBased Objects=[Stator, Rotor, Band, OuterRegion, InnerRegion] CurvedSurfaceApproxChoice=ManualSettings SurfDev=0.08mm NormalDev=15deg
  initial mesh: MeshMethod=AnsoftTAU
setups:
  Setup1: Transient NonlinearSolverResidual=0.0001 SmoothBHCurve StopTime=0.2s TimeStep=0.0002s InitialTimeStep=0.002s MinTimeStep=0.001s MaxTimeStep=0.003s TimeStepErrTolerance=0.0001
reports:
  Torque: Moving1.Torque vs Time on Setup1 : Transient
  Currents: Current(PhaseA), Current(PhaseB), Current(PhaseC) vs Time on Setup1 : Transient
  Induced Voltages: InducedVoltage(PhaseA), InducedVoltage(PhaseB), InducedVoltage(PhaseC) vs Time on Setup1 : Transient
  Flux Linkages: FluxLinkage(PhaseA), FluxLinkage(PhaseB), FluxLinkage(PhaseC) vs Time on Setup1 : Transient
  Voltages: InputVoltage(PhaseA), InputVoltage(PhaseB), InputVoltage(PhaseC) vs Time on Setup1 : Transient
  Powers: InputVoltage(PhaseA)*Current(PhaseA) + InputVoltage(PhaseB)*Current(PhaseB) + InputVoltage(PhaseC)*Current(PhaseC), Moving1.Speed*Moving1.Torque vs Time on Setup1 : Transient
  Torque Plot 1: Moving1.Torque vs Time on Setup1 : Transient
